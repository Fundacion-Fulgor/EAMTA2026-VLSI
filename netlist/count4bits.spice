** sch_path: /home/eamtastudent/EAMTA2026-VLSI/design/blocks/count4bits/schematic/count4bits.sch
**.subckt count4bits vdd clk rst vss 0b 1b 2b 3b
*.iopin vdd
*.iopin clk
*.iopin rst
*.iopin 0b
*.iopin 1b
*.iopin 2b
*.iopin 3b
x1 vdd clk vdd 0b rst vss count1bit
x2 vdd clk 0b 1b rst vss count1bit
x3 vdd clk 1b 2b rst vss count1bit
x4 vdd clk 2b 3b rst vss count1bit
**.ends

* expanding   symbol:  blocks/count1bit/schematic/count1bit.sym # of pins=6
** sym_path: /home/eamtastudent/EAMTA2026-VLSI/design/blocks/count1bit/schematic/count1bit.sym
** sch_path: /home/eamtastudent/EAMTA2026-VLSI/design/blocks/count1bit/schematic/count1bit.sch
.subckt count1bit vdd clk in out rst vss
*.iopin in
*.iopin clk
*.iopin out
*.iopin rst
*.iopin vss
*.iopin vdd
x2 net2 vdd in vss net1 xorgate
x1 vdd net2 in out vss andgate
x3 vss clk net2 rst net1 vdd dff
.ends

* expanding   symbol:  blocks/xorgate/schematic/xorgate.sym # of pins=5
** sym_path: /home/eamtastudent/EAMTA2026-VLSI/design/blocks/xorgate/schematic/xorgate.sym
** sch_path: /home/eamtastudent/EAMTA2026-VLSI/design/blocks/xorgate/schematic/xorgate.sch
.subckt xorgate a vdd b vss out
*.iopin a
*.iopin b
*.iopin vdd
*.iopin vss
*.iopin out
XM3 out a net1 vdd sg13_lv_pmos w=1.5u l=0.15u ng=1
XM1 out b net1 vdd sg13_lv_pmos w=1.5u l=1.5u ng=1
XM4 out na net2 vss sg13_lv_nmos w=1.5u l=0.15u ng=1
x1 vdd nb b vss inverter
x2 vdd na a vss inverter
XM2 net1 nb vdd vdd sg13_lv_pmos w=1.5u l=0.15u ng=1
XM5 net1 na vdd vdd sg13_lv_pmos w=1.5u l=0.15u ng=1
XM7 out a net3 vss sg13_lv_nmos w=1.5u l=0.15u ng=1
XM8 net2 nb vss vss sg13_lv_nmos w=1.5u l=0.15u ng=1
XM9 net3 b vss vss sg13_lv_nmos w=1.5u l=0.15u ng=1
.ends

* expanding   symbol:  blocks/andgate/schematic/andgate.sym # of pins=5
** sym_path: /home/eamtastudent/EAMTA2026-VLSI/design/blocks/andgate/schematic/andgate.sym
** sch_path: /home/eamtastudent/EAMTA2026-VLSI/design/blocks/andgate/schematic/andgate.sch
.subckt andgate vdd a b out vss
*.iopin b
*.iopin a
*.iopin vdd
*.iopin vss
*.iopin out
XM1 net1 b vss vss sg13_lv_nmos w=1.5u l=0.15u ng=1
XM4 net2 a vdd vdd sg13_lv_pmos w=1.5u l=0.15u ng=1
x1 vdd out net2 vss inverter
XM3 net2 a net1 vss sg13_lv_nmos w=1.5u l=0.15u ng=1
XM5 net2 b vdd vdd sg13_lv_pmos w=1.5u l=0.15u ng=1
.ends

* expanding   symbol:  blocks/dff/schematic/dff.sym # of pins=6
** sym_path: /home/eamtastudent/EAMTA2026-VLSI/design/blocks/dff/schematic/dff.sym
** sch_path: /home/eamtastudent/EAMTA2026-VLSI/design/blocks/dff/schematic/dff.sch
.subckt dff vss clk out rst in vdd
*.iopin vss
*.iopin in
*.iopin vdd
*.iopin out
*.iopin rst
*.iopin clk
*.iopin vss
x1 in vdd nclk net1 vss net6 transmissiongate
*  x1 -  andgate.sym:Zone  IS MISSING !!!!
x2 vdd rst net2 net3 vss norgate
x5 vdd net2 net1 vss inverter
x7 net3 vdd clk1 net1 vss nclk transmissiongate
x3 net3 vdd clk net4 vss nclk transmissiongate
x4 vdd rst net5 out vss norgate
x6 vdd net5 net4 vss inverter
x8 out vdd nclk net4 vss clk transmissiongate
x9 vdd nclk clk vss inverter
.ends

* expanding   symbol:  blocks/inverter/schematic/inverter.sym # of pins=4
** sym_path: /home/eamtastudent/EAMTA2026-VLSI/design/blocks/inverter/schematic/inverter.sym
** sch_path: /home/eamtastudent/EAMTA2026-VLSI/design/blocks/inverter/schematic/inverter.sch
.subckt inverter vdd out in vss
*.iopin vdd
*.iopin out
*.iopin vss
*.iopin in
XM1 out in vss vss sg13_lv_nmos w=0.75u l=0.15u ng=1
XM2 out in vdd vdd sg13_lv_pmos w=1.5u l=0.15u ng=1
.ends

* expanding   symbol:  blocks/transmissiongate/schematic/transmissiongate.sym # of pins=6
** sym_path: /home/eamtastudent/EAMTA2026-VLSI/design/blocks/transmissiongate/schematic/transmissiongate.sym
** sch_path: /home/eamtastudent/EAMTA2026-VLSI/design/blocks/transmissiongate/schematic/transmissiongate.sch
.subckt transmissiongate in vdd noten out vss en
*.iopin noten
*.iopin en
*.iopin in
*.iopin out
*.iopin vdd
*.iopin vss
XM1 out noten in vdd sg13_lv_pmos w=1.5u l=0.15u ng=1
XM2 out en in vss sg13_lv_nmos w=0.75u l=0.15u ng=1
.ends

* expanding   symbol:  blocks/norgate/schematic/norgate.sym # of pins=5
** sym_path: /home/eamtastudent/EAMTA2026-VLSI/design/blocks/norgate/schematic/norgate.sym
** sch_path: /home/eamtastudent/EAMTA2026-VLSI/design/blocks/norgate/schematic/norgate.sch
.subckt norgate vdd a b out vss
*.iopin vdd
*.iopin vss
*.iopin b
*.iopin a
*.iopin out
XM1 out a vss vss sg13_lv_nmos w=0.75u l=0.15u ng=1
XM4 out a net1 vdd sg13_lv_pmos w=3u l=0.15u ng=1
XM3 out b vss vss sg13_lv_nmos w=0.75u l=0.15u ng=1
XM5 net1 b vdd vdd sg13_lv_pmos w=3u l=0.15u ng=1
.ends

.end
