** sch_path: /home/eamtastudent/EAMTA2026-VLSI/design/blocks/inverter/schematic/inverter.sch
.subckt inverter vdd out in vss
*.PININFO vdd:B out:B vss:B in:B
M1 out in vss vss sg13_lv_nmos w=0.15u l=0.13u ng=1
M2 out in vdd vdd sg13_lv_pmos w=0.3u l=0.13u ng=1
.ends
