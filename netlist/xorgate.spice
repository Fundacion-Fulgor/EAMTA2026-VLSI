** sch_path: /home/eamtastudent/EAMTA2026-VLSI/design/blocks/xorgate/schematic/xorgate.sch
**.subckt xorgate a vdd b vss out
*.iopin a
*.iopin b
*.iopin vdd
*.iopin vss
*.iopin out
XM3 out a net1 vdd sg13_lv_pmos w=1.5u l=0.15u ng=1
XM1 out b net1 vdd sg13_lv_pmos w=1.5u l=1.5u ng=1
XM4 out na net2 vss sg13_lv_nmos w=1.5u l=0.15u ng=1
x1 vdd nb b vss inverter
x2 vdd na a vss inverter
XM2 net1 nb vdd vdd sg13_lv_pmos w=1.5u l=0.15u ng=1
XM5 net1 na vdd vdd sg13_lv_pmos w=1.5u l=0.15u ng=1
XM7 out a net3 vss sg13_lv_nmos w=1.5u l=0.15u ng=1
XM8 net2 nb vss vss sg13_lv_nmos w=1.5u l=0.15u ng=1
XM9 net3 b vss vss sg13_lv_nmos w=1.5u l=0.15u ng=1
**.ends

* expanding   symbol:  blocks/inverter/schematic/inverter.sym # of pins=4
** sym_path: /home/eamtastudent/EAMTA2026-VLSI/design/blocks/inverter/schematic/inverter.sym
** sch_path: /home/eamtastudent/EAMTA2026-VLSI/design/blocks/inverter/schematic/inverter.sch
.subckt inverter vdd out in vss
*.iopin vdd
*.iopin out
*.iopin vss
*.iopin in
XM1 out in vss vss sg13_lv_nmos w=0.75u l=0.15u ng=1
XM2 out in vdd vdd sg13_lv_pmos w=1.5u l=0.15u ng=1
.ends

.end
