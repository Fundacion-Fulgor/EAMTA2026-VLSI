* Extracted by KLayout with SG13G2 LVS runset on : 13/03/2026 19:46

.SUBCKT dff
M$1 \$1 \$10 \$21 \$1 sg13_lv_nmos L=0.15u W=0.75u AS=0.255p AD=0.1425p
+ PS=2.18u PD=1.13u
M$2 \$21 \$11 \$1 \$1 sg13_lv_nmos L=0.15u W=0.75u AS=0.1425p AD=0.255p
+ PS=1.13u PD=2.18u
M$3 \$1 \$13 \$23 \$1 sg13_lv_nmos L=0.15u W=0.75u AS=0.255p AD=0.1425p
+ PS=2.18u PD=1.13u
M$4 \$23 \$11 \$1 \$1 sg13_lv_nmos L=0.15u W=0.75u AS=0.1425p AD=0.255p
+ PS=1.13u PD=2.18u
M$5 \$8 \$2 \$9 \$1 sg13_lv_nmos L=0.15u W=0.75u AS=0.255p AD=0.255p PS=2.18u
+ PD=2.18u
M$6 \$21 \$3 \$9 \$1 sg13_lv_nmos L=0.15u W=0.75u AS=0.255p AD=0.255p PS=2.18u
+ PD=2.18u
M$7 \$21 \$3 \$12 \$1 sg13_lv_nmos L=0.15u W=0.75u AS=0.255p AD=0.255p PS=2.18u
+ PD=2.18u
M$8 \$23 \$2 \$12 \$1 sg13_lv_nmos L=0.15u W=0.75u AS=0.255p AD=0.255p PS=2.18u
+ PD=2.18u
M$9 \$1 \$9 \$10 \$1 sg13_lv_nmos L=0.15u W=0.75u AS=0.255p AD=0.255p PS=2.18u
+ PD=2.18u
M$10 \$1 \$12 \$13 \$1 sg13_lv_nmos L=0.15u W=0.75u AS=0.255p AD=0.255p
+ PS=2.18u PD=2.18u
M$11 \$21 \$10 \$22 \$20 sg13_lv_pmos L=0.15u W=3u AS=1.02p AD=0.57p PS=6.68u
+ PD=3.38u
M$12 \$22 \$11 \$20 \$20 sg13_lv_pmos L=0.15u W=3u AS=0.57p AD=1.02p PS=3.38u
+ PD=6.68u
M$13 \$23 \$13 \$24 \$20 sg13_lv_pmos L=0.15u W=3u AS=1.02p AD=0.57p PS=6.68u
+ PD=3.38u
M$14 \$24 \$11 \$20 \$20 sg13_lv_pmos L=0.15u W=3u AS=0.57p AD=1.02p PS=3.38u
+ PD=6.68u
M$15 \$8 \$3 \$9 \$20 sg13_lv_pmos L=0.15u W=1.5u AS=0.51p AD=0.51p PS=3.68u
+ PD=3.68u
M$16 \$20 \$9 \$10 \$20 sg13_lv_pmos L=0.15u W=1.5u AS=0.51p AD=0.51p PS=3.68u
+ PD=3.68u
M$17 \$21 \$2 \$9 \$20 sg13_lv_pmos L=0.15u W=1.5u AS=0.51p AD=0.51p PS=3.68u
+ PD=3.68u
M$18 \$21 \$2 \$12 \$20 sg13_lv_pmos L=0.15u W=1.5u AS=0.51p AD=0.51p PS=3.68u
+ PD=3.68u
M$19 \$20 \$12 \$13 \$20 sg13_lv_pmos L=0.15u W=1.5u AS=0.51p AD=0.51p PS=3.68u
+ PD=3.68u
M$20 \$23 \$3 \$12 \$20 sg13_lv_pmos L=0.15u W=1.5u AS=0.51p AD=0.51p PS=3.68u
+ PD=3.68u
.ENDS dff
