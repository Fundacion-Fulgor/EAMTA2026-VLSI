* NGSPICE file created from dff2c.ext - technology: sky130A

.subckt sky130_fd_pr__nfet_01v8_KRUHEH__0 a_15_n75# a_n15_n101# a_n73_n75# VSUBS
X0 a_15_n75# a_n15_n101# a_n73_n75# VSUBS sky130_fd_pr__nfet_01v8 ad=0.2175 pd=2.08 as=0.2175 ps=2.08 w=0.75 l=0.15
.ends

.subckt sky130_fd_pr__pfet_01v8_MDJ67A__0 a_15_n150# a_n15_n176# a_n73_n150# w_n109_n212#
X0 a_15_n150# a_n15_n176# a_n73_n150# w_n109_n212# sky130_fd_pr__pfet_01v8 ad=0.435 pd=3.58 as=0.435 ps=3.58 w=1.5 l=0.15
.ends

.subckt inverter vdd out in vss
Xsky130_fd_pr__nfet_01v8_KRUHEH_0 vss in out vss sky130_fd_pr__nfet_01v8_KRUHEH__0
Xsky130_fd_pr__pfet_01v8_MDJ67A_0 vdd in out vdd sky130_fd_pr__pfet_01v8_MDJ67A__0
.ends

.subckt sky130_fd_pr__pfet_01v8_MDJ67A a_15_n150# a_n15_n176# a_n73_n150# w_n109_n212#
X0 a_15_n150# a_n15_n176# a_n73_n150# w_n109_n212# sky130_fd_pr__pfet_01v8 ad=0.435 pd=3.58 as=0.435 ps=3.58 w=1.5 l=0.15
.ends

.subckt sky130_fd_pr__nfet_01v8_KRUHEH a_15_n75# a_n15_n101# a_n73_n75# VSUBS
X0 a_15_n75# a_n15_n101# a_n73_n75# VSUBS sky130_fd_pr__nfet_01v8 ad=0.2175 pd=2.08 as=0.2175 ps=2.08 w=0.75 l=0.15
.ends

.subckt norgate vdd b_in m1_215_245# a_in vss
Xsky130_fd_pr__pfet_01v8_MDJ67A_1 m1_303_886# a_in vdd vdd sky130_fd_pr__pfet_01v8_MDJ67A
Xsky130_fd_pr__pfet_01v8_MDJ67A_2 m1_215_245# b_in m1_303_886# vdd sky130_fd_pr__pfet_01v8_MDJ67A
Xsky130_fd_pr__pfet_01v8_MDJ67A_3 m1_303_886# b_in m1_215_245# vdd sky130_fd_pr__pfet_01v8_MDJ67A
Xsky130_fd_pr__nfet_01v8_KRUHEH_0 vss a_in m1_215_245# vss sky130_fd_pr__nfet_01v8_KRUHEH
Xsky130_fd_pr__nfet_01v8_KRUHEH_1 m1_215_245# b_in vss vss sky130_fd_pr__nfet_01v8_KRUHEH
Xsky130_fd_pr__pfet_01v8_MDJ67A_0 vdd a_in m1_303_886# vdd sky130_fd_pr__pfet_01v8_MDJ67A
.ends

.subckt sky130_fd_pr__nfet_01v8_KRUHEH__1 a_15_n75# a_n15_n101# a_n73_n75# VSUBS
X0 a_15_n75# a_n15_n101# a_n73_n75# VSUBS sky130_fd_pr__nfet_01v8 ad=0.2175 pd=2.08 as=0.2175 ps=2.08 w=0.75 l=0.15
.ends

.subckt sky130_fd_pr__pfet_01v8_MDJ67A__1 a_15_n150# a_n15_n176# a_n73_n150# w_n109_n212#
X0 a_15_n150# a_n15_n176# a_n73_n150# w_n109_n212# sky130_fd_pr__pfet_01v8 ad=0.435 pd=3.58 as=0.435 ps=3.58 w=1.5 l=0.15
.ends

.subckt transmissiongate viapoly_M1_0/sky130_fd_pr__nfet_01v8_3Y5EQC_0/a_n33_66# a_neg
+ out sky130_fd_pr__pfet_01v8_MDJ67A_0/a_n15_n176# viapoly_M1_1/sky130_fd_pr__nfet_01v8_3Y5EQC_0/a_n33_66#
+ in sky130_fd_pr__nfet_01v8_KRUHEH_0/a_n15_n101# VSUBS
Xsky130_fd_pr__nfet_01v8_KRUHEH_0 out sky130_fd_pr__nfet_01v8_KRUHEH_0/a_n15_n101#
+ in VSUBS sky130_fd_pr__nfet_01v8_KRUHEH__1
Xsky130_fd_pr__pfet_01v8_MDJ67A_0 out sky130_fd_pr__pfet_01v8_MDJ67A_0/a_n15_n176#
+ in a_neg sky130_fd_pr__pfet_01v8_MDJ67A__1
.ends

.ckt dff2c
Xinverter_0 vdd inverter_0/out inverter_0/in vss inverter
Xinverter_1 vdd inverter_1/out inverter_1/in vss inverter
Xinverter_2 vdd norgate_0/a_in inverter_2/in vss inverter
Xinverter_3 vdd inverter_3/out inverter_3/in vss inverter
Xnorgate_0 vdd norgate_1/b_in transmissiongate_1/in norgate_0/a_in vss norgate
Xnorgate_1 vdd norgate_1/b_in inverter_3/in norgate_1/a_in vss norgate
Xtransmissiongate_0 vdd vdd inverter_2/in inverter_1/out vss transmissiongate_0/in
+ inverter_1/in vss transmissiongate
Xtransmissiongate_1 vdd vdd inverter_2/in inverter_0/in vss transmissiongate_1/in
+ inverter_0/out vss transmissiongate
Xtransmissiongate_2 vdd vdd norgate_1/a_in inverter_1/out vss inverter_3/out inverter_1/in
+ vss transmissiongate
Xtransmissiongate_3 vdd vdd norgate_1/a_in inverter_0/in vss norgate_0/a_in inverter_0/out
+ vss transmissiongate
.end
